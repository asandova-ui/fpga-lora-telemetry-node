# Ansys Electronics Desktop project, version 2024.2
materials:
  copper: permeability=0.999991 conductivity=58000000
  FR4_epoxy: permittivity=4.4 dielectric_loss_tangent=0.02
  pec: conductivity=1e+30
  vacuum: permittivity=1

design Aproximacion1 (HFSS 3D Layout)
ports:
  Port1: Properties{Impedance=50ohm Magnitude=1V Phase=0deg Renormalize_Impedence="50ohm + 0i ohm" Renormalize Deembed_Distance=0cm Deembed Type=Probe HFSS_Type=Gap(coax) Orientation=Horizontal Layer_Alignment=Upper Horizontal_Extent_Factor=5 Vertical_Extent_Factor=3 PEC_Launch_Width=0cm} Type=ProbePort Pin=Port1 Upper{LoadType=CoaxProbe Properties{Upper_Parallel Upper_R=0ohm Upper_L=0nH Upper_C=0pF Upper_Real=0ohm Upper_Imag=0ohm Upper_Magnitude=1V Upper_Phase=0deg Upper_Impedance=50ohm}} Material=copper ViaMesh=Mesh Sides=3
setups:
  PlanarEMSetup1: SolveSetupType=PEM PercentRefinementPerPass=25 MinNumberOfPasses=1 MinNumberOfConvergedPasses=1 Frequency=868MHz MeshSizeFactor=10 ViaNumSides=1 Style25DVia=Wirebond
    sweep Sweep1: LIN 600MHz 1.2GHz 2MHz; SAbsError=0.005 ZoPercentError=1 PassivityTolerance=0.0001 MaxSolutions=250 InterpUseSMatrix InterpUsePortImpedance InterpUseFullBasis MinSolvedFreq=0.01GHz AutoSMatOnlySolve MinFreqSMatrixOnlySolve=1MHz MagMinThreshold=0.01 InterpMinSolutions=0 FreqSweepType=kInterpolating
reports:
  Report2D: dB(S(Port1,Port1)) vs Freq on PlanarEMSetup1 : Sweep1; markers m1 at 0.864GHz, m2 at 0.704GHz

design Aproximacion2 (HFSS 3D Layout)
ports:
  Port1: Properties{Impedance=50ohm Magnitude=1V Phase=0deg Renormalize_Impedence="50ohm + 0i ohm" Renormalize Deembed_Distance=0mm Deembed Type=Probe HFSS_Type=Gap(coax) Orientation=Horizontal Layer_Alignment=Upper Horizontal_Extent_Factor=5 Vertical_Extent_Factor=3 PEC_Launch_Width=0mm} Type=ProbePort Pin=Port1 Lower{LoadType=CoaxProbe Properties{Lower_Parallel Lower_R=0ohm Lower_L=0nH Lower_C=0pF Lower_Real=0ohm Lower_Imag=0ohm Lower_Magnitude=1V Lower_Phase=0deg Lower_Impedance=50ohm}} Material=copper ViaMesh=Mesh Sides=3
radiation setups:
  Infinite Sphere 1: Type=InfiniteSphereFarField StartTheta=0deg StartPhi=-180deg StopTheta=360deg StopPhi=180deg StepTheta=2deg StepPhi=2deg
  Infinite Sphere 2: Type=InfiniteSphereFarField StartTheta=0deg StartPhi=0deg StopTheta=360deg StopPhi=90deg StepTheta=2deg StepPhi=90deg
setups:
  PlanarEMSetup1: SolveSetupType=PEM PercentRefinementPerPass=25 MinNumberOfPasses=1 MinNumberOfConvergedPasses=1 Frequency=868MHz MeshSizeFactor=10 ViaNumSides=1 Style25DVia=Wirebond
    sweep Sweep1: LIN 600MHz 1200MHz 2MHz; SAbsError=0.005 ZoPercentError=1 PassivityTolerance=0.0001 MaxSolutions=250 InterpUseSMatrix InterpUsePortImpedance InterpUseFullBasis MinSolvedFreq=0.01GHz AutoSMatOnlySolve MinFreqSMatrixOnlySolve=1MHz MagMinThreshold=0.01 InterpMinSolutions=0 FreqSweepType=kInterpolating
    sweep Sweep2: 868MHz; GenerateSurfaceCurrent SAbsError=0.005 ZoPercentError=1 PassivityTolerance=0.0001 MaxSolutions=250 InterpUseSMatrix InterpUsePortImpedance InterpUseFullBasis MinSolvedFreq=0.01GHz AutoSMatOnlySolve MinFreqSMatrixOnlySolve=1MHz MagMinThreshold=0.01 InterpMinSolutions=0 FreqSweepType=kDiscrete
field plots:
  Mag_SurfaceJ1: J Surf on PlanarEMSetup1 : Sweep2 at Freq=0.868GHz Phase=0deg
reports:
  Report2D: dB(S(Port1,Port1)) vs Freq on PlanarEMSetup1 : Sweep1; markers m1 at 0.868GHz
  Report2D1: VSWR(Port1) vs Freq on PlanarEMSetup1 : Sweep1; markers m1 at 0.868GHz
  Phi: dB(GainInput) vs theta on PlanarEMSetup1 : Sweep2 [Theta=all Phi=all Freq=0.868GHz]
  Report3D: dB(GainInput) vs phi, theta on PlanarEMSetup1 : Sweep2 [Phi=all Theta=all Freq=0.868GHz]
  Z Parameter Plot 1: re(Z(Port1,Port1)), im(Z(Port1,Port1)) vs Freq on PlanarEMSetup1 : Sweep1; markers m1 at 0.868GHz, m2 at 0.868GHz

design Aproximacion5 (HFSS 3D Layout)
ports:
  Port1: Properties{Impedance=50ohm Magnitude=1V Phase=0deg Renormalize_Impedence="50ohm + 0i ohm" Renormalize Deembed_Distance=0mm Deembed Type=Probe HFSS_Type=Gap(coax) Orientation=Horizontal Layer_Alignment=Upper Horizontal_Extent_Factor=5 Vertical_Extent_Factor=3 PEC_Launch_Width=0mm} Type=ProbePort Pin=Port1 Lower{LoadType=CoaxProbe Properties{Lower_Parallel Lower_R=0ohm Lower_L=0nH Lower_C=0pF Lower_Real=0ohm Lower_Imag=0ohm Lower_Magnitude=1V Lower_Phase=0deg Lower_Impedance=50ohm}} Material=copper ViaMesh=Mesh Sides=3
setups:
  PlanarEMSetup1: SolveSetupType=PEM PercentRefinementPerPass=25 MinNumberOfPasses=1 MinNumberOfConvergedPasses=1 Frequency=868MHz MeshSizeFactor=10 ViaNumSides=1 Style25DVia=Wirebond
    sweep Sweep1: LIN 600MHz 1200MHz 2MHz; SAbsError=0.005 ZoPercentError=1 PassivityTolerance=0.0001 MaxSolutions=250 InterpUseSMatrix InterpUsePortImpedance InterpUseFullBasis MinSolvedFreq=0.01GHz AutoSMatOnlySolve MinFreqSMatrixOnlySolve=1MHz MagMinThreshold=0.01 InterpMinSolutions=0 FreqSweepType=kInterpolating
reports:
  Report2D: dB(S(Port1,Port1)) vs Freq on PlanarEMSetup1 : Sweep1; markers m1 at 0.868GHz, m2 at 0.904GHz

design Aproximacion3 (HFSS 3D Layout)
ports:
  Port1: Properties{Impedance=50ohm Magnitude=1V Phase=0deg Renormalize_Impedence="50ohm + 0i ohm" Renormalize Deembed_Distance=0mm Deembed Type=Probe HFSS_Type=Gap(coax) Orientation=Horizontal Layer_Alignment=Upper Horizontal_Extent_Factor=5 Vertical_Extent_Factor=3 PEC_Launch_Width=0mm} Type=ProbePort Pin=Port1 Lower{LoadType=CoaxProbe Properties{Lower_Parallel Lower_R=0ohm Lower_L=0nH Lower_C=0pF Lower_Real=0ohm Lower_Imag=0ohm Lower_Magnitude=1V Lower_Phase=0deg Lower_Impedance=50ohm}} Material=copper ViaMesh=Mesh Sides=3
setups:
  PlanarEMSetup1: SolveSetupType=PEM PercentRefinementPerPass=25 MinNumberOfPasses=1 MinNumberOfConvergedPasses=1 Frequency=868MHz MeshSizeFactor=10 ViaNumSides=1 Style25DVia=Wirebond
    sweep Sweep1: LIN 600MHz 1200MHz 2MHz; SAbsError=0.005 ZoPercentError=1 PassivityTolerance=0.0001 MaxSolutions=250 InterpUseSMatrix InterpUsePortImpedance InterpUseFullBasis MinSolvedFreq=0.01GHz AutoSMatOnlySolve MinFreqSMatrixOnlySolve=1MHz MagMinThreshold=0.01 InterpMinSolutions=0 FreqSweepType=kInterpolating
reports:
  Report2D: dB(S(Port1,Port1)) vs Freq on PlanarEMSetup1 : Sweep1; markers m1 at 0.868GHz, m2 at 0.844GHz

design Aproximacion6 (HFSS 3D Layout)
ports:
  Port1: Properties{Impedance=50ohm Magnitude=1V Phase=0deg Renormalize_Impedence="50ohm + 0i ohm" Renormalize Deembed_Distance=0mm Deembed Type=Probe HFSS_Type=Gap(coax) Orientation=Horizontal Layer_Alignment=Upper Horizontal_Extent_Factor=5 Vertical_Extent_Factor=3 PEC_Launch_Width=0mm} Type=ProbePort Pin=Port1 Lower{LoadType=CoaxProbe Properties{Lower_Parallel Lower_R=0ohm Lower_L=0nH Lower_C=0pF Lower_Real=0ohm Lower_Imag=0ohm Lower_Magnitude=1V Lower_Phase=0deg Lower_Impedance=50ohm}} Material=copper ViaMesh=Mesh Sides=3
radiation setups:
  Infinite Sphere 1: Type=InfiniteSphereFarField StartTheta=0deg StartPhi=-180deg StopTheta=360deg StopPhi=180deg StepTheta=2deg StepPhi=2deg
  Infinite Sphere 2: Type=InfiniteSphereFarField StartTheta=0deg StartPhi=0deg StopTheta=360deg StopPhi=90deg StepTheta=2deg StepPhi=90deg
setups:
  PlanarEMSetup1: SolveSetupType=PEM PercentRefinementPerPass=25 MinNumberOfPasses=1 MinNumberOfConvergedPasses=1 Frequency=868MHz MeshSizeFactor=10 ViaNumSides=1 Style25DVia=Wirebond
    sweep Sweep1: LIN 600MHz 1200MHz 2MHz; SAbsError=0.005 ZoPercentError=1 PassivityTolerance=0.0001 MaxSolutions=250 InterpUseSMatrix InterpUsePortImpedance InterpUseFullBasis MinSolvedFreq=0.01GHz AutoSMatOnlySolve MinFreqSMatrixOnlySolve=1MHz MagMinThreshold=0.01 InterpMinSolutions=0 FreqSweepType=kInterpolating
    sweep Sweep2: 868MHz; GenerateSurfaceCurrent SAbsError=0.005 ZoPercentError=1 PassivityTolerance=0.0001 MaxSolutions=250 InterpUseSMatrix InterpUsePortImpedance InterpUseFullBasis MinSolvedFreq=0.01GHz AutoSMatOnlySolve MinFreqSMatrixOnlySolve=1MHz MagMinThreshold=0.01 InterpMinSolutions=0 FreqSweepType=kDiscrete
field plots:
  Mag_SurfaceJ1: J Surf on PlanarEMSetup1 : Sweep2 at Freq=0.868GHz Phase=0deg
reports:
  Report2D: dB(S(Port1,Port1)) vs Freq on PlanarEMSetup1 : Sweep1; markers m1 at 0.868GHz
  Report2D1: VSWR(Port1) vs Freq on PlanarEMSetup1 : Sweep1; markers m1 at 0.868GHz
  Z Parameter Plot 2: re(Z(Port1,Port1)), im(Z(Port1,Port1)) vs Freq on PlanarEMSetup1 : Sweep1; markers m1 at 0.868GHz, m2 at 0.868GHz
  Report3D: dB(GainInput) vs phi, theta on PlanarEMSetup1 : Sweep2 [Phi=all Theta=all Freq=0.868GHz]
  Report2D2: dB(GainInput) vs theta on PlanarEMSetup1 : Sweep2 [Theta=all Phi=all Freq=0.868GHz]

design Aproximacion4 (HFSS 3D Layout)
ports:
  Port1: Properties{Impedance=50ohm Magnitude=1V Phase=0deg Renormalize_Impedence="50ohm + 0i ohm" Renormalize Deembed_Distance=0mm Deembed Type=Probe HFSS_Type=Gap(coax) Orientation=Horizontal Layer_Alignment=Upper Horizontal_Extent_Factor=5 Vertical_Extent_Factor=3 PEC_Launch_Width=0mm} Type=ProbePort Pin=Port1 Lower{LoadType=CoaxProbe Properties{Lower_Parallel Lower_R=0ohm Lower_L=0nH Lower_C=0pF Lower_Real=0ohm Lower_Imag=0ohm Lower_Magnitude=1V Lower_Phase=0deg Lower_Impedance=50ohm}} Material=copper ViaMesh=Mesh Sides=3
radiation setups:
  Infinite Sphere 1: Type=InfiniteSphereFarField StartTheta=0deg StartPhi=-180deg StopTheta=360deg StopPhi=180deg StepTheta=2deg StepPhi=2deg
  Infinite Sphere 2: Type=InfiniteSphereFarField StartTheta=0deg StartPhi=0deg StopTheta=360deg StopPhi=90deg StepTheta=2deg StepPhi=90deg
setups:
  PlanarEMSetup1: SolveSetupType=PEM PercentRefinementPerPass=25 MinNumberOfPasses=1 MinNumberOfConvergedPasses=1 Frequency=868MHz MeshSizeFactor=10 ViaNumSides=1 Style25DVia=Wirebond
    sweep Sweep1: LIN 600MHz 1200MHz 2MHz; SAbsError=0.005 ZoPercentError=1 PassivityTolerance=0.0001 MaxSolutions=250 InterpUseSMatrix InterpUsePortImpedance InterpUseFullBasis MinSolvedFreq=0.01GHz AutoSMatOnlySolve MinFreqSMatrixOnlySolve=1MHz MagMinThreshold=0.01 InterpMinSolutions=0 FreqSweepType=kInterpolating
    sweep Sweep2: 868MHz; GenerateSurfaceCurrent SAbsError=0.005 ZoPercentError=1 PassivityTolerance=0.0001 MaxSolutions=250 InterpUseSMatrix InterpUsePortImpedance InterpUseFullBasis MinSolvedFreq=0.01GHz AutoSMatOnlySolve MinFreqSMatrixOnlySolve=1MHz MagMinThreshold=0.01 InterpMinSolutions=0 FreqSweepType=kDiscrete
field plots:
  Mag_SurfaceJ1: J Surf on PlanarEMSetup1 : Sweep2 at Freq=0.868GHz Phase=0deg
reports:
  Report2D: dB(S(Port1,Port1)) vs Freq on PlanarEMSetup1 : Sweep1; markers m1 at 0.868GHz
  Report2D1: VSWR(Port1) vs Freq on PlanarEMSetup1 : Sweep1; markers m1 at 0.868GHz
  Z Parameter Plot 3: re(Z(Port1,Port1)), im(Z(Port1,Port1)) vs Freq on PlanarEMSetup1 : Sweep1; markers m1 at 0.868GHz, m2 at 0.868GHz
  Report3D: dB(GainInput) vs phi, theta on PlanarEMSetup1 : Sweep2 [Phi=all Theta=all Freq=0.868GHz]
  Report2D2: dB(GainInput) vs theta on PlanarEMSetup1 : Sweep2 [Theta=all Phi=all Freq=0.868GHz]
